`include "disciplines.vams"
module duration_voltage(p, out);
    inout p, out;
    electrical p, out;
    (* type="instance" *) parameter real tau=1;
    analog I(out) <+ absdelay(V(p), tau+V(p), 10);
endmodule
