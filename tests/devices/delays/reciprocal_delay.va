`include "disciplines.vams"
module reciprocal_delay(p, out);
    inout p, out;
    electrical p, out;
    (* type="instance" *) parameter real tau=1;
    analog I(out) <+ 1/absdelay(V(p)+1, tau);
endmodule
