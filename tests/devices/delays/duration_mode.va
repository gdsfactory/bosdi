`include "disciplines.vams"
module duration_mode(p, out);
    inout p, out;
    electrical p, out;
    (* type="instance" *) parameter real tau=1;
    analog I(out) <+ absdelay(V(p), analysis("tran") ? 2*tau : tau);
endmodule
