`include "disciplines.vams"
module variable_delay(p, out);
    inout p, out;
    electrical p, out;
    (* type="instance" *) parameter real tau=1;
    analog I(out) <+ absdelay(V(p), tau, 2.0);
endmodule
